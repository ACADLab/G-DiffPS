* Minimal two-stage Miller OTA in SKY130 — DC operating point + AC gain.
* Integration check inspired by opensrc_analog miller OTA examples
* (third_party/opensrc_analog/example_sch/). Project-local SPICE, not an
* xschem netlist export.
*
* Diff pair + PMOS mirror load + NMOS bias + CS second stage + Miller C.

.param VDD=1.8
.param IBIAS=20u
.param CL=2p
.param CM=500f

Vdd vdd 0 {VDD}
Ibias vdd nbias {IBIAS}

* Differential inputs at Vcm=0.9 V; AC on vip only
Vinp vip 0 DC 0.9 AC 1
Vinn vin 0 DC 0.9

* Bias diode
XMnb nbias nbias 0 0 sky130_fd_pr__nfet_01v8 L=0.5 W=2 nf=1 ad='2*0.29' as='2*0.29' pd='2*(2+0.29)' ps='2*(2+0.29)'

* Tail
XMtail ntail nbias 0 0 sky130_fd_pr__nfet_01v8 L=0.5 W=4 nf=1 ad='4*0.29' as='4*0.29' pd='2*(4+0.29)' ps='2*(4+0.29)'

* Diff pair
XMn1 out1 vip ntail 0 sky130_fd_pr__nfet_01v8 L=0.5 W=4 nf=1 ad='4*0.29' as='4*0.29' pd='2*(4+0.29)' ps='2*(4+0.29)'
XMn2 out2 vin ntail 0 sky130_fd_pr__nfet_01v8 L=0.5 W=4 nf=1 ad='4*0.29' as='4*0.29' pd='2*(4+0.29)' ps='2*(4+0.29)'

* PMOS current-mirror load
XMp1 out1 out1 vdd vdd sky130_fd_pr__pfet_01v8 L=0.5 W=8 nf=1 ad='8*0.29' as='8*0.29' pd='2*(8+0.29)' ps='2*(8+0.29)'
XMp2 out2 out1 vdd vdd sky130_fd_pr__pfet_01v8 L=0.5 W=8 nf=1 ad='8*0.29' as='8*0.29' pd='2*(8+0.29)' ps='2*(8+0.29)'

* Second stage
XMn3 vout nbias 0 0 sky130_fd_pr__nfet_01v8 L=0.5 W=8 nf=1 ad='8*0.29' as='8*0.29' pd='2*(8+0.29)' ps='2*(8+0.29)'
XMp3 vout out2 vdd vdd sky130_fd_pr__pfet_01v8 L=0.5 W=16 nf=1 ad='16*0.29' as='16*0.29' pd='2*(16+0.29)' ps='2*(16+0.29)'

Cmill out2 vout {CM}
Cload vout 0 {CL}

.control
  op
  let vout_op = v(vout)
  let vtail = v(ntail)
  let vnbias = v(nbias)
  echo vout_op = $&vout_op
  echo vtail = $&vtail
  echo vnbias = $&vnbias

  ac dec 10 1k 10meg
  let mag = db(v(vout))
  let gain_db_1k = mag[0]
  echo gain_db_1k = $&gain_db_1k
  quit
.endc

.end
