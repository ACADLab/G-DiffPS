* SKY130 MIM capacitor cap_mim_m3_1 — AC capacitance estimate
* C ≈ |I| / (2*pi*f*|Vac|)

Vac a 0 DC 0 AC 0.01
XC a 0 sky130_fd_pr__cap_mim_m3_1 W=5 L=5 mf=1

.control
  ac lin 1 1e6 1e6
  let iac = abs(i(Vac))
  let c_est = iac / (6.283185307179586 * 1.0e6 * 0.01)
  echo iac = $&iac
  echo c_est = $&c_est
  quit
.endc

.end
